.title ROBERGE.ONEBOX.W00_06 semantic connectivity
.subckt W00_04_IDEAL_OPAMP INP INM OUT VP VN COMPA COMPB
.ends W00_04_IDEAL_OPAMP
.subckt MZ4445562E524547312E455252 PZ494E50 PZ494E4D PZ4F5554 PZ503135 PZ4E3135 PZ53474E44
CIZ524547312E4343 NZ524547312E434F4D5041 NZ524547312E434F4D5042 30p
CIZ524547312E434E PZ53474E44 PZ4E3135 0.1u
CIZ524547312E4350 PZ503135 PZ53474E44 0.1u
XIZ524547312E555F455252 PZ494E50 PZ494E4D PZ4F5554 PZ503135 PZ4E3135 NZ524547312E434F4D5041 NZ524547312E434F4D5042 W00_04_IDEAL_OPAMP
.ends MZ4445562E524547312E455252
XIZ4445562E524547312E455252 NZ524547312E56524546 NZ524547312E53454E5345 NZ524547312E4552525F4F5554 NZ503135 NZ4E3135 0 MZ4445562E524547312E455252
.end

.title OP_AMPS_ROBERGE_W12 semantic connectivity
.subckt W00_04_IDEAL_OPAMP INP INM OUT VP VN COMPA COMPB
.ends W00_04_IDEAL_OPAMP
.subckt MZ5731332E494E54322E54455354 PZ56494E PZ53554D PZ4F5554 PZ434F4D5041 PZ434F4D5042 PZ474E44
CIZ5731332E494E54322E43435F53454C454354 PZ434F4D5041 PZ434F4D5042 30p
RIZ5731332E494E54322E524642 PZ4F5554 PZ53554D 4.70k
RIZ5731332E494E54322E52494E PZ56494E PZ53554D 4.70k
RIZ5731332E494E54322E524C4F4144 PZ4F5554 PZ474E44 10Meg
VIZ5731332E494E54322E56535243 PZ56494E PZ474E44 PULSE(0 -50m 10m 1u 1u 20m 50m)
.ends MZ5731332E494E54322E54455354
.subckt MZ4D4F442E494E5432 PZ494E PZ4F5554 PZ4A41434B PZ56503135 PZ564E3135 PZ53474E44 PZ434F4D5041 PZ434F4D5042
XIZ4445562E494E5432 PZ53474E44 NZ494E54322E53554D PZ4F5554 PZ56503135 PZ564E3135 PZ53474E44 NZ5731322E5457494E2E4F5554 PZ434F4D5041 PZ434F4D5042 MZ4445562E494E5432
.ends MZ4D4F442E494E5432
.subckt MZ494E462E5057525F454E545259 PZ56503135 PZ564E3135 PZ53474E44 PZ50474E44
CIZ494E462E43424E PZ53474E44 PZ564E3135 10u
CIZ494E462E434250 PZ56503135 PZ53474E44 10u
VIZ494E462E474E445F544945 PZ50474E44 PZ53474E44 0
VIZ494E462E564E3135 PZ50474E44 PZ564E3135 15
VIZ494E462E56503135 PZ56503135 PZ50474E44 15
.ends MZ494E462E5057525F454E545259
.subckt MZ4445562E494E5432 PZ494E50 PZ494E4D PZ4F5554 PZ56503135 PZ564E3135 PZ53474E44 PZ5457494E5F4F5554 PZ434F4D5041 PZ434F4D5042
XIZ4445562E555F494E5432 PZ494E50 PZ494E4D PZ4F5554 PZ56503135 PZ564E3135 PZ434F4D5041 PZ434F4D5042 W00_04_IDEAL_OPAMP
CIZ494E54322E434E PZ494E50 PZ564E3135 0.1u
CIZ494E54322E4350 PZ56503135 PZ494E50 0.1u
.ends MZ4445562E494E5432
.subckt MZ43484153534953 PZ56503135 PZ564E3135 PZ53474E44 PZ50474E44
XIZ494E462E5057525F454E545259 PZ56503135 PZ564E3135 PZ53474E44 PZ50474E44 MZ494E462E5057525F454E545259
XIZ4D4F442E494E5432 NZ494E54322E494E NZ494E54322E4F5554 NZ494E54322E4A41434B PZ56503135 PZ564E3135 PZ53474E44 NZ494E54322E434F4D5041 NZ494E54322E434F4D5042 MZ4D4F442E494E5432
XIZ5731332E494E54322E54455354 NZ5731332E494E54322E56494E NZ494E54322E53554D NZ494E54322E4F5554 NZ494E54322E434F4D5041 NZ494E54322E434F4D5042 PZ53474E44 MZ5731332E494E54322E54455354
.ends MZ43484153534953
XIZ43484153534953 NZ503135 NZ4E3135 0 NZ50474E44 MZ43484153534953
.end

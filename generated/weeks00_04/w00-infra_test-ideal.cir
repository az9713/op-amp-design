.title ROBERGE.ONEBOX.W00_04 semantic connectivity
.subckt MZ494E462E5057525F454E545259 PZ56503135 PZ564E3135 PZ53474E44 PZ50474E44
CIZ494E462E43424E PZ53474E44 PZ564E3135 10u
CIZ494E462E434250 PZ56503135 PZ53474E44 10u
VIZ494E462E474E445F544945 PZ50474E44 PZ53474E44 0
RIZ494E462E5244554D4D595F4E PZ50474E44 PZ564E3135 3.3k
RIZ494E462E5244554D4D595F50 PZ56503135 PZ50474E44 3.3k
VIZ494E462E564E3135 PZ50474E44 PZ564E3135 15
VIZ494E462E56503135 PZ56503135 PZ50474E44 15
.ends MZ494E462E5057525F454E545259
.subckt MZ43484153534953 PZ56503135 PZ564E3135 PZ53474E44 PZ50474E44
XIZ494E462E5057525F454E545259 PZ56503135 PZ564E3135 PZ53474E44 PZ50474E44 MZ494E462E5057525F454E545259
.ends MZ43484153534953
XIZ43484153534953 NZ503135 NZ4E3135 0 NZ50474E44 MZ43484153534953
.end

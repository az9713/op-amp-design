.title OP_AMPS_ROBERGE_W12 semantic connectivity
.subckt W00_04_IDEAL_OPAMP INP INM OUT VP VN COMPA COMPB
.ends W00_04_IDEAL_OPAMP
.subckt MZ5731332E4C41475F53554D PZ53554D PZ474E44
CIZ5731332E4C41475F53554D2E43 NZ5731332E4C41475F53554D2E5243 PZ474E44 C_LAG_SUM
RIZ5731332E4C41475F53554D2E52 PZ53554D NZ5731332E4C41475F53554D2E5243 R_LAG_SUM
.ends MZ5731332E4C41475F53554D
.subckt MZ4D4F442E53554D31 PZ494E41 PZ494E42 PZ494E43 PZ4F5554 PZ4A41434B PZ56503135 PZ564E3135 PZ53474E44 PZ4C41475F4E4F4445
RIZ53554D312E524642 PZ4F5554 PZ4C41475F4E4F4445 10k
RIZ53554D312E52494E5F41 NZ4649582E53554D41 PZ4C41475F4E4F4445 10k
RIZ53554D312E524F5554 PZ4F5554 PZ4A41434B 100
XIZ4445562E53554D31 PZ53474E44 PZ4C41475F4E4F4445 PZ4F5554 PZ56503135 PZ564E3135 PZ53474E44 MZ4445562E53554D31
.ends MZ4D4F442E53554D31
.subckt MZ4D4541532E46495854555245 PZ53474E44
RIZ4649582E524C4F4144 NZ53554D312E4A41434B PZ53474E44 10Meg
VIZ4649582E565F53554D41 NZ4649582E53554D41 PZ53474E44 DC 0.5
.ends MZ4D4541532E46495854555245
.subckt MZ494E462E5057525F454E545259 PZ56503135 PZ564E3135 PZ53474E44 PZ50474E44
CIZ494E462E43424E PZ53474E44 PZ564E3135 10u
CIZ494E462E434250 PZ56503135 PZ53474E44 10u
VIZ494E462E474E445F544945 PZ50474E44 PZ53474E44 0
VIZ494E462E564E3135 PZ50474E44 PZ564E3135 15
VIZ494E462E56503135 PZ56503135 PZ50474E44 15
.ends MZ494E462E5057525F454E545259
.subckt MZ4445562E53554D31 PZ494E50 PZ494E4D PZ4F5554 PZ56503135 PZ564E3135 PZ53474E44
XIZ4445562E555F53554D31 PZ494E50 PZ494E4D PZ4F5554 PZ56503135 PZ564E3135 NZ53554D312E434F4D5041 NZ53554D312E434F4D5042 W00_04_IDEAL_OPAMP
CIZ53554D312E43433330 NZ53554D312E434F4D5041 NZ53554D312E434F4D5042 30p
CIZ53554D312E434E PZ494E50 PZ564E3135 0.1u
CIZ53554D312E4350 PZ56503135 PZ494E50 0.1u
.ends MZ4445562E53554D31
.subckt MZ43484153534953 PZ56503135 PZ564E3135 PZ53474E44 PZ50474E44
XIZ494E462E5057525F454E545259 PZ56503135 PZ564E3135 PZ53474E44 PZ50474E44 MZ494E462E5057525F454E545259
XIZ4D4541532E46495854555245 PZ53474E44 MZ4D4541532E46495854555245
XIZ4D4F442E53554D31 NZ53554D312E494E41 NZ53554D312E494E42 NZ53554D312E494E43 NZ53554D312E4F5554 NZ53554D312E4A41434B PZ56503135 PZ564E3135 PZ53474E44 NZ53554D312E53554D MZ4D4F442E53554D31
XIZ5731332E4C41475F53554D NZ53554D312E53554D PZ53474E44 MZ5731332E4C41475F53554D
.ends MZ43484153534953
XIZ43484153534953 NZ503135 NZ4E3135 0 NZ50474E44 MZ43484153534953
.end

.title ROBERGE.ONEBOX.W00_06 semantic connectivity
.subckt W00_04_EMPTY_SOCKET VP VN GND IN OUT
.ends W00_04_EMPTY_SOCKET
.subckt W00_04_IDEAL_OPAMP INP INM OUT VP VN COMPA COMPB
.ends W00_04_IDEAL_OPAMP
.subckt MZ4445562E524547312E455252 PZ494E50 PZ494E4D PZ4F5554 PZ503135 PZ4E3135 PZ53474E44
CIZ524547312E4343 NZ524547312E434F4D5041 NZ524547312E434F4D5042 30p
CIZ524547312E434E PZ53474E44 PZ4E3135 0.1u
CIZ524547312E4350 PZ503135 PZ53474E44 0.1u
XIZ524547312E555F455252 PZ494E50 PZ494E4D PZ4F5554 PZ503135 PZ4E3135 NZ524547312E434F4D5041 NZ524547312E434F4D5042 W00_04_IDEAL_OPAMP
.ends MZ4445562E524547312E455252
.subckt MZ4D4F442E53554D31 PZ494E41 PZ494E42 PZ494E43 PZ4F5554 PZ4A41434B PZ56503135 PZ564E3135 PZ53474E44
RIZ53554D312E524642 PZ4F5554 NZ53554D312E53554D 10k
RIZ53554D312E52494E5F41 PZ494E41 NZ53554D312E53554D 10k
RIZ53554D312E52494E5F42 PZ494E42 NZ53554D312E53554D 10k
RIZ53554D312E52494E5F43 PZ494E43 NZ53554D312E53554D 10k
RIZ53554D312E524F5554 PZ4F5554 PZ4A41434B 100
XIZ4445562E53554D31 PZ53474E44 NZ53554D312E53554D PZ4F5554 PZ56503135 PZ564E3135 PZ53474E44 MZ4445562E53554D31
.ends MZ4D4F442E53554D31
.subckt MZ4D4F442E534F434B455453 PZ56503135 PZ564E3135 PZ53474E44
XIZ534C4F542E494E54322E4D41524B4552 PZ56503135 PZ564E3135 PZ53474E44 NZ534C4F542E494E54322E494E NZ534C4F542E494E54322E4F5554 W00_04_EMPTY_SOCKET
XIZ534C4F542E494E54332E4D41524B4552 PZ56503135 PZ564E3135 PZ53474E44 NZ534C4F542E494E54332E494E NZ534C4F542E494E54332E4F5554 W00_04_EMPTY_SOCKET
.ends MZ4D4F442E534F434B455453
.subckt MZ4D4F442E494E5631 PZ494E PZ4F5554 PZ4A41434B PZ56503135 PZ564E3135 PZ53474E44
RIZ494E56312E524642 PZ4F5554 NZ494E56312E53554D 4.70k
RIZ494E56312E52494E PZ494E NZ494E56312E53554D 4.70k
RIZ494E56312E524F5554 PZ4F5554 PZ4A41434B 100
XIZ4445562E494E5631 PZ53474E44 NZ494E56312E53554D PZ4F5554 PZ56503135 PZ564E3135 PZ53474E44 MZ4445562E494E5631
.ends MZ4D4F442E494E5631
.subckt MZ4D4F442E494E5432 PZ494E PZ4F5554 PZ4A41434B PZ56503135 PZ564E3135 PZ53474E44
CIZ494E54322E434642 PZ4F5554 NZ494E54322E53554D 1u
RIZ494E54322E52494E PZ494E NZ494E54322E53554D 10k
RIZ494E54322E524F5554 PZ4F5554 PZ4A41434B 100
XIZ4445562E494E5432 PZ53474E44 NZ494E54322E53554D PZ4F5554 PZ56503135 PZ564E3135 PZ53474E44 MZ4445562E494E5432
.ends MZ4D4F442E494E5432
.subckt MZ4D4F442E494E5431 PZ494E PZ4F5554 PZ4A41434B PZ56503135 PZ564E3135 PZ53474E44
CIZ494E54312E434642 PZ4F5554 NZ494E54312E53554D 1u
RIZ494E54312E52494E PZ494E NZ494E54312E53554D 10k
RIZ494E54312E524F5554 PZ4F5554 PZ4A41434B 100
XIZ4445562E494E5431 PZ53474E44 NZ494E54312E53554D PZ4F5554 PZ56503135 PZ564E3135 PZ53474E44 MZ4445562E494E5431
.ends MZ4D4F442E494E5431
.subckt MZ494E462E5057525F454E545259 PZ56503135 PZ564E3135 PZ53474E44 PZ50474E44
CIZ494E462E43424E PZ53474E44 PZ564E3135 10u
CIZ494E462E434250 PZ56503135 PZ53474E44 10u
VIZ494E462E474E445F544945 PZ50474E44 PZ53474E44 0
VIZ494E462E564E3135 PZ50474E44 PZ564E3135 15
VIZ494E462E56503135 PZ56503135 PZ50474E44 15
.ends MZ494E462E5057525F454E545259
.subckt MZ4445562E53554D31 PZ494E50 PZ494E4D PZ4F5554 PZ56503135 PZ564E3135 PZ53474E44
XIZ4445562E555F53554D31 PZ494E50 PZ494E4D PZ4F5554 PZ56503135 PZ564E3135 NZ53554D312E434F4D5041 NZ53554D312E434F4D5042 W00_04_IDEAL_OPAMP
CIZ53554D312E43433330 NZ53554D312E434F4D5041 NZ53554D312E434F4D5042 30p
CIZ53554D312E434E PZ494E50 PZ564E3135 0.1u
CIZ53554D312E4350 PZ56503135 PZ494E50 0.1u
.ends MZ4445562E53554D31
.subckt MZ4445562E494E5631 PZ494E50 PZ494E4D PZ4F5554 PZ56503135 PZ564E3135 PZ53474E44
XIZ4445562E555F494E5631 PZ494E50 PZ494E4D PZ4F5554 PZ56503135 PZ564E3135 NZ494E56312E434F4D5041 NZ494E56312E434F4D5042 W00_04_IDEAL_OPAMP
CIZ494E56312E43433330 NZ494E56312E434F4D5041 NZ494E56312E434F4D5042 30p
CIZ494E56312E434E PZ494E50 PZ564E3135 0.1u
CIZ494E56312E4350 PZ56503135 PZ494E50 0.1u
.ends MZ4445562E494E5631
.subckt MZ4445562E494E5432 PZ494E50 PZ494E4D PZ4F5554 PZ56503135 PZ564E3135 PZ53474E44
XIZ4445562E555F494E5432 PZ494E50 PZ494E4D PZ4F5554 PZ56503135 PZ564E3135 NZ494E54322E434F4D5041 NZ494E54322E434F4D5042 W00_04_IDEAL_OPAMP
CIZ494E54322E43433330 NZ494E54322E434F4D5041 NZ494E54322E434F4D5042 30p
CIZ494E54322E434E PZ494E50 PZ564E3135 0.1u
CIZ494E54322E4350 PZ56503135 PZ494E50 0.1u
.ends MZ4445562E494E5432
.subckt MZ4445562E494E5431 PZ494E50 PZ494E4D PZ4F5554 PZ56503135 PZ564E3135 PZ53474E44
XIZ4445562E555F494E54315F53544F434B PZ494E50 PZ494E4D PZ4F5554 PZ56503135 PZ564E3135 NZ494E54312E434F4D5041 NZ494E54312E434F4D5042 W00_04_IDEAL_OPAMP
CIZ494E54312E4343323230 NZ494E54312E434F4D5041 NZ494E54312E434F4D5042 220p
CIZ494E54312E434E PZ494E50 PZ564E3135 0.1u
CIZ494E54312E4350 PZ56503135 PZ494E50 0.1u
.ends MZ4445562E494E5431
.subckt MZ52454731 PZ56554E524547 PZ564F5554 PZ503135 PZ4E3135 PZ53474E44
CIZ524547312E435F4C4F4144 NZ524547312E434C4F41445F4E PZ53474E44 CL_CASE
CIZ524547312E435F524546 NZ524547312E56524546 PZ53474E44 10u
DIZ524547312E445F4449534348 PZ564F5554 PZ56554E524547 W0506_RECT
DIZ524547312E445F524546 PZ53474E44 NZ524547312E56524546 W0506_Z10
IIZ524547312E495F44495354 PZ564F5554 PZ53474E44 PULSE(0 10m 20m 10u 10u 20m 100m)
QIZ524547312E515F50415353 PZ56554E524547 NZ524547312E5142415345 NZ524547312E51454D4954 W0506_NPN_BASE
RIZ524547312E525F42415345 NZ524547312E4552525F4F5554 NZ524547312E5142415345 1k
RIZ524547312E525F424C454544 PZ564F5554 PZ53474E44 10k
RIZ524547312E525F454D4954 NZ524547312E51454D4954 PZ564F5554 100
RIZ524547312E525F455352 PZ564F5554 NZ524547312E434C4F41445F4E 0.30
RIZ524547312E525F4C4F4144 PZ564F5554 PZ53474E44 RL_CASE
RIZ524547312E525F524546 PZ503135 NZ524547312E56524546 330
RIZ524547312E525F53434F5045 PZ564F5554 PZ53474E44 10Meg
VIZ524547312E565F4C4F4F505F494E4A PZ564F5554 NZ524547312E53454E5345 DC 0 AC 1
VIZ524547312E565F554E524547 PZ56554E524547 PZ53474E44 18
XIZ4445562E524547312E455252 NZ524547312E56524546 NZ524547312E53454E5345 NZ524547312E4552525F4F5554 PZ503135 PZ4E3135 PZ53474E44 MZ4445562E524547312E455252
.ends MZ52454731
.subckt MZ43484153534953 PZ56503135 PZ564E3135 PZ53474E44 PZ50474E44
XIZ494E462E5057525F454E545259 PZ56503135 PZ564E3135 PZ53474E44 PZ50474E44 MZ494E462E5057525F454E545259
XIZ4D4F442E494E5431 NZ494E54312E494E NZ494E54312E4F5554 NZ494E54312E4A41434B PZ56503135 PZ564E3135 PZ53474E44 MZ4D4F442E494E5431
XIZ4D4F442E494E5432 NZ494E54322E494E NZ494E54322E4F5554 NZ494E54322E4A41434B PZ56503135 PZ564E3135 PZ53474E44 MZ4D4F442E494E5432
XIZ4D4F442E494E5631 NZ494E56312E494E NZ494E56312E4F5554 NZ494E56312E4A41434B PZ56503135 PZ564E3135 PZ53474E44 MZ4D4F442E494E5631
XIZ4D4F442E534F434B455453 PZ56503135 PZ564E3135 PZ53474E44 MZ4D4F442E534F434B455453
XIZ4D4F442E53554D31 NZ53554D312E494E41 NZ53554D312E494E42 NZ53554D312E494E43 NZ53554D312E4F5554 NZ53554D312E4A41434B PZ56503135 PZ564E3135 PZ53474E44 MZ4D4F442E53554D31
XIZ52454731 NZ524547312E56554E524547 NZ524547312E564F5554 PZ56503135 PZ564E3135 PZ53474E44 MZ52454731
.ends MZ43484153534953
XIZ43484153534953 NZ503135 NZ4E3135 0 NZ50474E44 MZ43484153534953
.end

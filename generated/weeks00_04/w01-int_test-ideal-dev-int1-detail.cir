.title ROBERGE.ONEBOX.W00_04 semantic connectivity
.subckt W00_04_IDEAL_OPAMP INP INM OUT VP VN COMPA COMPB
.ends W00_04_IDEAL_OPAMP
.subckt MZ4445562E494E5431 PZ494E50 PZ494E4D PZ4F5554 PZ56503135 PZ564E3135 PZ53474E44
XIZ4445562E555F494E54315F53544F434B PZ494E50 PZ494E4D PZ4F5554 PZ56503135 PZ564E3135 NZ494E54312E434F4D5041 NZ494E54312E434F4D5042 W00_04_IDEAL_OPAMP
CIZ494E54312E43433330 NZ494E54312E434F4D5041 NZ494E54312E434F4D5042 30p
CIZ494E54312E434E PZ494E50 PZ564E3135 0.1u
CIZ494E54312E4350 PZ56503135 PZ494E50 0.1u
.ends MZ4445562E494E5431
XIZ4445562E494E5431 0 NZ494E54312E53554D NZ494E54312E4F5554 NZ503135 NZ4E3135 0 MZ4445562E494E5431
.end

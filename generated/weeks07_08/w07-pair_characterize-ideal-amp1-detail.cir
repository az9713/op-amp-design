.title ROBERGE.ONEBOX.W00_08 semantic connectivity
.subckt MZ414D5031 PZ494E565F494E PZ4E4F4E494E565F494E PZ4F5554 PZ434F4D505F41 PZ434F4D505F42 PZ56503135 PZ564E3135 PZ41474E44
CIZ414D50312E435F424941535F47 NZ414D50312E4E2E424941535F4E4547 PZ41474E44 0.1u
CIZ414D50312E435F424941535F4E NZ414D50312E4E2E424941535F4E4547 PZ564E3135 33u
DIZ414D50312E445F42414C PZ56503135 NZ414D50312E4E2E42414C5F57 W09_D_BASE
DIZ414D50312E445F42494153 NZ414D50312E4E2E424941535F44494F44455F41 PZ564E3135 W09_D_BASE
QIZ414D50312E5131 NZ414D50312E4E2E5131435F513442 PZ494E565F494E NZ414D50312E4E2E5441494C W09_NPN_BASE
QIZ414D50312E5132 PZ434F4D505F41 PZ4E4F4E494E565F494E NZ414D50312E4E2E5441494C W09_NPN_BASE
QIZ414D50312E5133 NZ414D50312E4E2E5441494C NZ414D50312E4E2E424941535F4E4547 NZ414D50312E4E2E5133455F534552494553 W09_NPN_BASE
RIZ414D50312E525F42414C5F4C NZ414D50312E4E2E42414C5F4C NZ414D50312E4E2E42414C5F57 25k
RIZ414D50312E525F42414C5F52 NZ414D50312E4E2E42414C5F57 NZ414D50312E4E2E42414C5F52 25k
RIZ414D50312E525F424941535F5443 NZ414D50312E4E2E424941535F4E4547 NZ414D50312E4E2E424941535F44494F44455F41 1.5k
RIZ414D50312E525F434F4C5F4C NZ414D50312E4E2E42414C5F4C NZ414D50312E4E2E5131435F513442 300k
RIZ414D50312E525F434F4C5F52 NZ414D50312E4E2E42414C5F52 PZ434F4D505F41 300k
RIZ414D50312E525F51335F3138304B NZ414D50312E4E2E5133455F4D4944 PZ564E3135 180k
RIZ414D50312E525F51335F354B36 NZ414D50312E4E2E5133455F534552494553 NZ414D50312E4E2E5133455F4D4944 5.6k
.ends MZ414D5031
XIZ414D5031 NZ414D50312E494E565F494E NZ414D50312E4E4F4E494E565F494E NZ414D50312E4F5554 NZ414D50312E434F4D505F41 NZ414D50312E434F4D505F42 NZ503135 NZ4E3135 0 MZ414D5031
.end

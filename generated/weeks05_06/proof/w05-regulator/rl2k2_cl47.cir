.title ROBERGE.ONEBOX.W00_06.PROOF.REG1 semantic connectivity
.param CL=47u
.param RL=2.2k
.subckt W00_04_IDEAL_OPAMP INP INM OUT VP VN COMPA COMPB
BOUT OUT 0 V=13*tanh(1e4*(V(INP)-V(INM)))
RINP INP 0 1G
RINM INM 0 1G
RCOMPA COMPA 0 1T
RCOMPB COMPB 0 1T
.ends W00_04_IDEAL_OPAMP
.model W0506_NPN_BASE NPN(BF=100 VAF=100 IS=1e-14)
.model W0506_Z10 D(IS=1e-12 N=1.5 BV=10 IBV=10m)
.model W0506_Z5V1 D(IS=1e-12 N=1.5 BV=5.1 IBV=5m)
.model W0506_RECT D(IS=1e-9 N=1.8)
.subckt MZ4445562E524547312E455252 PZ494E50 PZ494E4D PZ4F5554 PZ503135 PZ4E3135 PZ53474E44
CIZ524547312E4343 NZ524547312E434F4D5041 NZ524547312E434F4D5042 30p
CIZ524547312E434E PZ53474E44 PZ4E3135 0.1u
CIZ524547312E4350 PZ503135 PZ53474E44 0.1u
XIZ524547312E555F455252 PZ494E50 PZ494E4D PZ4F5554 PZ503135 PZ4E3135 NZ524547312E434F4D5041 NZ524547312E434F4D5042 W00_04_IDEAL_OPAMP
.ends MZ4445562E524547312E455252
.subckt MZ494E462E5057525F454E545259 PZ56503135 PZ564E3135 PZ53474E44 PZ50474E44
CIZ494E462E43424E PZ53474E44 PZ564E3135 10u
CIZ494E462E434250 PZ56503135 PZ53474E44 10u
VIZ494E462E474E445F544945 PZ50474E44 PZ53474E44 0
VIZ494E462E564E3135 PZ50474E44 PZ564E3135 15
VIZ494E462E56503135 PZ56503135 PZ50474E44 15
.ends MZ494E462E5057525F454E545259
.subckt MZ52454731 PZ56554E524547 PZ564F5554 PZ503135 PZ4E3135 PZ53474E44
CIZ524547312E435F4C4F4144 NZ524547312E434C4F41445F4E PZ53474E44 {CL}
CIZ524547312E435F524546 NZ524547312E56524546 PZ53474E44 10u
DIZ524547312E445F4449534348 PZ564F5554 PZ56554E524547 W0506_RECT
DIZ524547312E445F524546 PZ53474E44 NZ524547312E56524546 W0506_Z10
IIZ524547312E495F44495354 PZ564F5554 PZ53474E44 PULSE(0 10m 20m 10u 10u 20m 100m)
QIZ524547312E515F50415353 PZ56554E524547 NZ524547312E5142415345 NZ524547312E51454D4954 W0506_NPN_BASE
RIZ524547312E525F42415345 NZ524547312E4552525F4F5554 NZ524547312E5142415345 1k
RIZ524547312E525F424C454544 PZ564F5554 PZ53474E44 10k
RIZ524547312E525F454D4954 NZ524547312E51454D4954 PZ564F5554 100
RIZ524547312E525F455352 PZ564F5554 NZ524547312E434C4F41445F4E 0.30
RIZ524547312E525F4C4F4144 PZ564F5554 PZ53474E44 {RL}
RIZ524547312E525F524546 PZ503135 NZ524547312E56524546 330
RIZ524547312E525F53434F5045 PZ564F5554 PZ53474E44 10Meg
VIZ524547312E565F4C4F4F505F494E4A PZ564F5554 NZ524547312E53454E5345 DC 0 AC 1
VIZ524547312E565F554E524547 PZ56554E524547 PZ53474E44 18
XIZ4445562E524547312E455252 NZ524547312E56524546 NZ524547312E53454E5345 NZ524547312E4552525F4F5554 PZ503135 PZ4E3135 PZ53474E44 MZ4445562E524547312E455252
.ends MZ52454731
.subckt MZ43484153534953 PZ56503135 PZ564E3135 PZ53474E44 PZ50474E44
XIZ494E462E5057525F454E545259 PZ56503135 PZ564E3135 PZ53474E44 PZ50474E44 MZ494E462E5057525F454E545259
XIZ52454731 NZ524547312E56554E524547 NZ524547312E564F5554 PZ56503135 PZ564E3135 PZ53474E44 MZ52454731
.ends MZ43484153534953
XIZ43484153534953 NZ503135 NZ4E3135 0 NZ50474E44 MZ43484153534953
.control
set wr_singlescale
set wr_vecnames
op
wrdata result_op.dat v(xiz43484153534953.NZ524547312E564F5554) v(xiz43484153534953.xiz52454731.NZ524547312E56524546)
ac dec 10 0.1 100k
wrdata result_ac.dat frequency v(xiz43484153534953.NZ524547312E564F5554)
tran 100u 200m 0
wrdata result_tran.dat time v(xiz43484153534953.NZ524547312E564F5554)
quit
.endc
.end

.title ROBERGE.ONEBOX.W00_06 semantic connectivity
.subckt W00_04_IDEAL_OPAMP INP INM OUT VP VN COMPA COMPB
.ends W00_04_IDEAL_OPAMP
.subckt MZ4445562E4F5343312E5343484D495454 PZ494E50 PZ494E4D PZ4F5554 PZ503135 PZ4E3135 PZ53474E44
XIZ4F5343312E555F5343484D495454 PZ494E50 PZ494E4D PZ4F5554 PZ503135 PZ4E3135 NZ4F5343312E5343485F434F4D5041 NZ4F5343312E5343485F434F4D5042 W00_04_IDEAL_OPAMP
CIZ4F5343312E555F5343484D4954542E4343 NZ4F5343312E5343485F434F4D5041 NZ4F5343312E5343485F434F4D5042 30p
CIZ4F5343312E555F5343484D4954542E434E PZ494E4D PZ4E3135 0.1u
CIZ4F5343312E555F5343484D4954542E4350 PZ503135 PZ494E4D 0.1u
.ends MZ4445562E4F5343312E5343484D495454
XIZ4445562E4F5343312E5343484D495454 NZ4F5343312E5343484D4954545F53554D 0 NZ4F5343312E5241575F535155415245 NZ503135 NZ4E3135 0 MZ4445562E4F5343312E5343484D495454
.end

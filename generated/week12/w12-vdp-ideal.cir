.title OP_AMPS_ROBERGE_W12 semantic connectivity
.subckt W00_04_EMPTY_SOCKET VP VN GND IN OUT
.ends W00_04_EMPTY_SOCKET
.subckt W00_04_IDEAL_OPAMP INP INM OUT VP VN COMPA COMPB
.ends W00_04_IDEAL_OPAMP
.subckt W12_AD633_IDEAL_INTERFACE X1 X2 Y1 Y2 Z W VP VN
.ends W12_AD633_IDEAL_INTERFACE
.subckt MZ5731322E5644502E4E4554 PZ44315F4E4547 PZ58 PZ58325F4449563130 PZ4E4F4E4C494E PZ56503135 PZ564E3135 PZ41474E44
CIZ5731322E5644502E435F414343454C PZ44315F4E4547 NZ414D50312E494E565F494E 1u
CIZ5731322E5644502E435F4431 PZ58 NZ494E54322E53554D 1u
RIZ5731322E5644502E525F4431 PZ44315F4E4547 NZ494E54322E53554D 1Meg
RIZ5731322E5644502E525F4C494E454152 NZ53554D312E4F5554 NZ414D50312E494E565F494E 1Meg
RIZ5731322E5644502E525F4E4F4E494E565F474E44 NZ414D50312E4E4F4E494E565F494E PZ41474E44 0
RIZ5731322E5644502E525F4E4F4E4C494E PZ4E4F4E4C494E NZ414D50312E494E565F494E 10k
RIZ5731322E5644502E525F53434F50455F58 PZ58 PZ41474E44 10Meg
RIZ5731322E5644502E525F53554D5F4431 PZ44315F4E4547 NZ53554D312E53554D 1Meg
RIZ5731322E5644502E525F53554D5F4642 NZ53554D312E4F5554 NZ53554D312E53554D 1Meg
RIZ5731322E5644502E525F53554D5F58 PZ58 NZ53554D312E53554D 1Meg
XIZ5731322E5644502E4D31 PZ58 PZ58325F4449563130 PZ56503135 PZ564E3135 PZ41474E44 MZ5731322E5644502E4D31
XIZ5731322E5644502E4D32 PZ58325F4449563130 PZ44315F4E4547 PZ4E4F4E4C494E PZ56503135 PZ564E3135 PZ41474E44 MZ5731322E5644502E4D32
.ends MZ5731322E5644502E4E4554
.subckt MZ5731322E5644502E4D32 PZ5832 PZ44315F4E4547 PZ57 PZ56503135 PZ564E3135 PZ41474E44
CIZ5731322E5644502E434E32 PZ41474E44 PZ564E3135 0.1u
CIZ5731322E5644502E435032 PZ56503135 PZ41474E44 0.1u
XIZ5731322E5644502E4D5F58324431 PZ5832 PZ41474E44 PZ44315F4E4547 PZ41474E44 PZ41474E44 PZ57 PZ56503135 PZ564E3135 W12_AD633_IDEAL_INTERFACE
.ends MZ5731322E5644502E4D32
.subckt MZ5731322E5644502E4D31 PZ585F59 PZ57 PZ56503135 PZ564E3135 PZ41474E44
CIZ5731322E5644502E434E31 PZ41474E44 PZ564E3135 0.1u
CIZ5731322E5644502E435031 PZ56503135 PZ41474E44 0.1u
XIZ5731322E5644502E4D5F5832 PZ585F59 PZ41474E44 PZ585F59 PZ41474E44 PZ41474E44 PZ57 PZ56503135 PZ564E3135 W12_AD633_IDEAL_INTERFACE
.ends MZ5731322E5644502E4D31
.subckt MZ4445562E524547312E455252 PZ494E50 PZ494E4D PZ4F5554 PZ503135 PZ4E3135 PZ53474E44
CIZ524547312E4343 NZ524547312E434F4D5041 NZ524547312E434F4D5042 30p
CIZ524547312E434E PZ53474E44 PZ4E3135 0.1u
CIZ524547312E4350 PZ503135 PZ53474E44 0.1u
XIZ524547312E555F455252 PZ494E50 PZ494E4D PZ4F5554 PZ503135 PZ4E3135 NZ524547312E434F4D5041 NZ524547312E434F4D5042 W00_04_IDEAL_OPAMP
.ends MZ4445562E524547312E455252
.subckt MZ4D4F442E53554D31 PZ494E41 PZ494E42 PZ494E43 PZ4F5554 PZ4A41434B PZ56503135 PZ564E3135 PZ53474E44
XIZ4445562E53554D31 PZ53474E44 NZ53554D312E53554D PZ4F5554 PZ56503135 PZ564E3135 PZ53474E44 MZ4445562E53554D31
.ends MZ4D4F442E53554D31
.subckt MZ4D4F442E534F434B455453 PZ56503135 PZ564E3135 PZ53474E44
XIZ534C4F542E494E54322E4D41524B4552 PZ56503135 PZ564E3135 PZ53474E44 NZ534C4F542E494E54322E494E NZ534C4F542E494E54322E4F5554 W00_04_EMPTY_SOCKET
.ends MZ4D4F442E534F434B455453
.subckt MZ4D4F442E494E5432 PZ494E PZ4F5554 PZ4A41434B PZ56503135 PZ564E3135 PZ53474E44
XIZ4445562E494E5432 PZ53474E44 NZ494E54322E53554D PZ4F5554 PZ56503135 PZ564E3135 PZ53474E44 NZ5731322E5457494E2E4F5554 MZ4445562E494E5432
.ends MZ4D4F442E494E5432
.subckt MZ494E462E5057525F454E545259 PZ56503135 PZ564E3135 PZ53474E44 PZ50474E44
CIZ494E462E43424E PZ53474E44 PZ564E3135 10u
CIZ494E462E434250 PZ56503135 PZ53474E44 10u
VIZ494E462E474E445F544945 PZ50474E44 PZ53474E44 0
VIZ494E462E564E3135 PZ50474E44 PZ564E3135 15
VIZ494E462E56503135 PZ56503135 PZ50474E44 15
.ends MZ494E462E5057525F454E545259
.subckt MZ4445562E53554D31 PZ494E50 PZ494E4D PZ4F5554 PZ56503135 PZ564E3135 PZ53474E44
XIZ4445562E555F53554D31 PZ494E50 PZ494E4D PZ4F5554 PZ56503135 PZ564E3135 NZ53554D312E434F4D5041 NZ53554D312E434F4D5042 W00_04_IDEAL_OPAMP
CIZ53554D312E43433330 NZ53554D312E434F4D5041 NZ53554D312E434F4D5042 30p
CIZ53554D312E434E PZ494E50 PZ564E3135 0.1u
CIZ53554D312E4350 PZ56503135 PZ494E50 0.1u
.ends MZ4445562E53554D31
.subckt MZ4445562E494E5432 PZ494E50 PZ494E4D PZ4F5554 PZ56503135 PZ564E3135 PZ53474E44 PZ5457494E5F4F5554
XIZ4445562E555F494E5432 PZ494E50 PZ494E4D PZ4F5554 PZ56503135 PZ564E3135 NZ494E54322E434F4D5041 NZ494E54322E434F4D5042 W00_04_IDEAL_OPAMP
CIZ494E54322E43433330 NZ494E54322E434F4D5041 NZ494E54322E434F4D5042 30p
CIZ494E54322E434E PZ494E50 PZ564E3135 0.1u
CIZ494E54322E4350 PZ56503135 PZ494E50 0.1u
.ends MZ4445562E494E5432
.subckt MZ414D50312E435231 PZ524546 PZ4F5554 PZ56503135
QIZ414D50312E515F43525F4F5554 PZ4F5554 PZ524546 PZ56503135 W09_PNP_BASE
QIZ414D50312E515F43525F524546 PZ524546 PZ524546 PZ56503135 W09_PNP_BASE
.ends MZ414D50312E435231
.subckt MZ52454731 PZ56554E524547 PZ564F5554 PZ503135 PZ4E3135 PZ53474E44
CIZ524547312E435F4C4F4144 NZ524547312E434C4F41445F4E PZ53474E44 CL_CASE
CIZ524547312E435F524546 NZ524547312E56524546 PZ53474E44 10u
DIZ524547312E445F4449534348 PZ564F5554 PZ56554E524547 W0506_RECT
DIZ524547312E445F524546 PZ53474E44 NZ524547312E56524546 W0506_Z10
IIZ524547312E495F44495354 PZ564F5554 PZ53474E44 PULSE(0 10m 20m 10u 10u 20m 100m)
QIZ524547312E515F50415353 PZ56554E524547 NZ524547312E5142415345 NZ524547312E51454D4954 W0506_NPN_BASE
RIZ524547312E525F42415345 NZ524547312E4552525F4F5554 NZ524547312E5142415345 1k
RIZ524547312E525F424C454544 PZ564F5554 PZ53474E44 10k
RIZ524547312E525F454D4954 NZ524547312E51454D4954 PZ564F5554 100
RIZ524547312E525F455352 PZ564F5554 NZ524547312E434C4F41445F4E 0.30
RIZ524547312E525F4C4F4144 PZ564F5554 PZ53474E44 RL_CASE
RIZ524547312E525F524546 PZ503135 NZ524547312E56524546 330
RIZ524547312E525F53434F5045 PZ564F5554 PZ53474E44 10Meg
VIZ524547312E565F4C4F4F505F494E4A PZ564F5554 NZ524547312E53454E5345 DC 0 AC 1
VIZ524547312E565F554E524547 PZ56554E524547 PZ53474E44 18
XIZ4445562E524547312E455252 NZ524547312E56524546 NZ524547312E53454E5345 NZ524547312E4552525F4F5554 PZ503135 PZ4E3135 PZ53474E44 MZ4445562E524547312E455252
.ends MZ52454731
.subckt MZ5245435431 PZ494E PZ4F5554 PZ56503135 PZ564E3135 PZ41474E44
CIZ52454354312E434E PZ41474E44 PZ564E3135 0.1u
CIZ52454354312E4350 PZ56503135 PZ41474E44 0.1u
CIZ52454354312E435F434F4D50 NZ52454354312E434F4D505F41 NZ52454354312E434F4D505F42 30p
DIZ52454354312E4431 NZ52454354312E4452495645 PZ4F5554 W09_D_BASE
RIZ52454354312E525F4C4F4144 PZ4F5554 PZ41474E44 10k
XIZ52454354312E5531 PZ494E PZ4F5554 NZ52454354312E4452495645 PZ56503135 PZ564E3135 NZ52454354312E434F4D505F41 NZ52454354312E434F4D505F42 W00_04_IDEAL_OPAMP
VIZ52454354312E56494E PZ494E PZ41474E44 SIN(0 1 1k)
.ends MZ5245435431
.subckt MZ43484153534953 PZ56503135 PZ564E3135 PZ53474E44 PZ50474E44
XIZ414D5031 NZ414D50312E494E565F494E NZ414D50312E4E4F4E494E565F494E NZ414D50312E4F5554 NZ414D50312E434F4D505F41 NZ414D50312E434F4D505F42 PZ56503135 PZ564E3135 PZ53474E44 MZ414D5031
XIZ494E462E5057525F454E545259 PZ56503135 PZ564E3135 PZ53474E44 PZ50474E44 MZ494E462E5057525F454E545259
XIZ4D4F442E494E5432 NZ494E54322E494E NZ494E54322E4F5554 NZ494E54322E4A41434B PZ56503135 PZ564E3135 PZ53474E44 MZ4D4F442E494E5432
XIZ4D4F442E534F434B455453 PZ56503135 PZ564E3135 PZ53474E44 MZ4D4F442E534F434B455453
XIZ4D4F442E53554D31 NZ53554D312E494E41 NZ53554D312E494E42 NZ53554D312E494E43 NZ53554D312E4F5554 NZ53554D312E4A41434B PZ56503135 PZ564E3135 PZ53474E44 MZ4D4F442E53554D31
XIZ5245435431 NZ52454354312E494E NZ52454354312E4F5554 PZ56503135 PZ564E3135 PZ53474E44 MZ5245435431
XIZ52454731 NZ524547312E56554E524547 NZ524547312E564F5554 PZ56503135 PZ564E3135 PZ53474E44 MZ52454731
XIZ5731322E5644502E4E4554 NZ414D50312E4F5554 NZ494E54322E4F5554 NZ5731322E5644502E58325F4449563130 NZ5731322E5644502E4E4F4E4C494E PZ56503135 PZ564E3135 PZ53474E44 MZ5731322E5644502E4E4554
.ends MZ43484153534953
.subckt MZ414D5031 PZ494E565F494E PZ4E4F4E494E565F494E PZ4F5554 PZ434F4D505F41 PZ434F4D505F42 PZ56503135 PZ564E3135 PZ41474E44
CIZ414D50312E4343 PZ434F4D505F41 PZ434F4D505F42 47p
CIZ414D50312E435F424941535F47 NZ414D50312E4E2E424941535F4E4547 PZ41474E44 0.1u
CIZ414D50312E435F424941535F4E NZ414D50312E4E2E424941535F4E4547 PZ564E3135 33u
CIZ414D50312E435F5134355F45 PZ56503135 NZ414D50312E4E2E51343545 3.3u
CIZ414D50312E435F5134425F425950 PZ56503135 NZ414D50312E4E2E5131435F513442 0.01u
CIZ414D50312E435F51365F425950 NZ414D50312E4E2E513642 PZ41474E44 1u
CIZ414D50312E435F564E5F42554C4B PZ41474E44 PZ564E3135 15u
CIZ414D50312E435F564E5F46415354 PZ41474E44 PZ564E3135 0.1u
CIZ414D50312E435F56505F42554C4B PZ56503135 PZ41474E44 15u
CIZ414D50312E435F56505F46415354 PZ56503135 PZ41474E44 0.1u
DIZ414D50312E445F42414C PZ56503135 NZ414D50312E4E2E42414C5F57 W09_D_BASE
DIZ414D50312E445F42494153 NZ414D50312E4E2E424941535F44494F44455F41 PZ564E3135 W09_D_BASE
DIZ414D50312E445F4452565F31 PZ434F4D505F42 NZ414D50312E4E2E4452565F44494F44455F4D4944 W09_D_BASE
DIZ414D50312E445F4452565F32 NZ414D50312E4E2E4452565F44494F44455F4D4944 NZ414D50312E4E2E4452565F4E5F513943 W09_D_BASE
QIZ414D50312E5131 NZ414D50312E4E2E5131435F513442 PZ494E565F494E NZ414D50312E4E2E5441494C W09_NPN_BASE
QIZ414D50312E513130 PZ56503135 PZ434F4D505F42 NZ414D50312E4E2E4F55545F505F53454E5345 W09_NPN_BASE
QIZ414D50312E513131 PZ564E3135 NZ414D50312E4E2E4452565F4E5F513943 NZ414D50312E4E2E4F55545F4E5F53454E5345 W09_PNP_BASE
QIZ414D50312E513132 PZ434F4D505F42 NZ414D50312E4E2E4F55545F505F53454E5345 PZ4F5554 W09_NPN_BASE
QIZ414D50312E513133 NZ414D50312E4E2E4452565F4E5F513943 NZ414D50312E4E2E4F55545F4E5F53454E5345 PZ4F5554 W09_PNP_BASE
QIZ414D50312E5132 PZ434F4D505F41 PZ4E4F4E494E565F494E NZ414D50312E4E2E5441494C W09_NPN_BASE
QIZ414D50312E5133 NZ414D50312E4E2E5441494C NZ414D50312E4E2E424941535F4E4547 NZ414D50312E4E2E5133455F534552494553 W09_NPN_BASE
QIZ414D50312E5134 PZ41474E44 NZ414D50312E4E2E5131435F513442 NZ414D50312E4E2E51343545 W09_PNP_BASE
QIZ414D50312E5135 NZ414D50312E4E2E5135435F513645 PZ434F4D505F41 NZ414D50312E4E2E51343545 W09_PNP_BASE
QIZ414D50312E5136 NZ414D50312E4E2E484947485F5A NZ414D50312E4E2E513642 NZ414D50312E4E2E5135435F513645 W09_PNP_BASE
QIZ414D50312E5137 NZ414D50312E4E2E484947485F5A NZ414D50312E4E2E424941535F4E4547 NZ414D50312E4E2E513745 W09_NPN_BASE
JIZ414D50312E5138 PZ56503135 NZ414D50312E4E2E484947485F5A PZ434F4D505F42 W09_NJF_BASE
QIZ414D50312E5139 NZ414D50312E4E2E4452565F4E5F513943 NZ414D50312E4E2E424941535F4E4547 NZ414D50312E4E2E513945 W09_NPN_BASE
RIZ414D50312E525F42414C5F4C NZ414D50312E4E2E42414C5F4C NZ414D50312E4E2E42414C5F57 25k
RIZ414D50312E525F42414C5F52 NZ414D50312E4E2E42414C5F57 NZ414D50312E4E2E42414C5F52 25k
RIZ414D50312E525F424941535F5443 NZ414D50312E4E2E424941535F4E4547 NZ414D50312E4E2E424941535F44494F44455F41 1.5k
RIZ414D50312E525F434F4C5F4C NZ414D50312E4E2E42414C5F4C NZ414D50312E4E2E5131435F513442 300k
RIZ414D50312E525F434F4C5F52 NZ414D50312E4E2E42414C5F52 PZ434F4D505F41 300k
RIZ414D50312E525F4F55545F4E PZ4F5554 NZ414D50312E4E2E4F55545F4E5F53454E5345 22
RIZ414D50312E525F4F55545F50 NZ414D50312E4E2E4F55545F505F53454E5345 PZ4F5554 22
RIZ414D50312E525F51335F3138304B NZ414D50312E4E2E5133455F4D4944 PZ564E3135 180k
RIZ414D50312E525F51335F354B36 NZ414D50312E4E2E5133455F534552494553 NZ414D50312E4E2E5133455F4D4944 5.6k
RIZ414D50312E525F5134355F45 PZ56503135 NZ414D50312E4E2E51343545 33k
RIZ414D50312E525F51365F4247 NZ414D50312E4E2E513642 PZ41474E44 10k
RIZ414D50312E525F51365F4250 PZ56503135 NZ414D50312E4E2E513642 4.7k
RIZ414D50312E525F51375F45 NZ414D50312E4E2E513745 PZ564E3135 68k
RIZ414D50312E525F51395F45 NZ414D50312E4E2E513945 PZ564E3135 1.5k
XIZ414D50312E435231 NZ414D50312E4E2E5131435F513442 PZ434F4D505F41 PZ56503135 MZ414D50312E435231
.ends MZ414D5031
XIZ43484153534953 NZ503135 NZ4E3135 0 NZ50474E44 MZ43484153534953
.end

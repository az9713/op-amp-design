.title ROBERGE.ONEBOX.W00_06 semantic connectivity
.subckt W00_04_EMPTY_SOCKET VP VN GND IN OUT
.ends W00_04_EMPTY_SOCKET
.subckt W00_04_IDEAL_OPAMP INP INM OUT VP VN COMPA COMPB
.ends W00_04_IDEAL_OPAMP
.subckt MZ4445562E524547312E455252 PZ494E50 PZ494E4D PZ4F5554 PZ503135 PZ4E3135 PZ53474E44
CIZ524547312E4343 NZ524547312E434F4D5041 NZ524547312E434F4D5042 30p
CIZ524547312E434E PZ53474E44 PZ4E3135 0.1u
CIZ524547312E4350 PZ503135 PZ53474E44 0.1u
XIZ524547312E555F455252 PZ494E50 PZ494E4D PZ4F5554 PZ503135 PZ4E3135 NZ524547312E434F4D5041 NZ524547312E434F4D5042 W00_04_IDEAL_OPAMP
.ends MZ4445562E524547312E455252
.subckt MZ4445562E4F5343312E5343484D495454 PZ494E50 PZ494E4D PZ4F5554 PZ503135 PZ4E3135 PZ53474E44
XIZ4F5343312E555F5343484D495454 PZ494E50 PZ494E4D PZ4F5554 PZ503135 PZ4E3135 NZ4F5343312E5343485F434F4D5041 NZ4F5343312E5343485F434F4D5042 W00_04_IDEAL_OPAMP
CIZ4F5343312E555F5343484D4954542E4343 NZ4F5343312E5343485F434F4D5041 NZ4F5343312E5343485F434F4D5042 30p
CIZ4F5343312E555F5343484D4954542E434E PZ494E4D PZ4E3135 0.1u
CIZ4F5343312E555F5343484D4954542E4350 PZ503135 PZ494E4D 0.1u
.ends MZ4445562E4F5343312E5343484D495454
.subckt MZ4D4F442E53554D31 PZ494E41 PZ494E42 PZ494E43 PZ4F5554 PZ4A41434B PZ56503135 PZ564E3135 PZ53474E44
RIZ53554D312E524642 PZ4F5554 NZ53554D312E53554D 10k
RIZ53554D312E52494E5F41 PZ494E41 NZ53554D312E53554D 10k
RIZ53554D312E52494E5F42 PZ494E42 NZ53554D312E53554D 10k
RIZ53554D312E52494E5F43 PZ494E43 NZ53554D312E53554D 10k
RIZ53554D312E524F5554 PZ4F5554 PZ4A41434B 100
XIZ4445562E53554D31 PZ53474E44 NZ53554D312E53554D PZ4F5554 PZ56503135 PZ564E3135 PZ53474E44 MZ4445562E53554D31
.ends MZ4D4F442E53554D31
.subckt MZ4D4F442E534F434B455453 PZ56503135 PZ564E3135 PZ53474E44
XIZ534C4F542E494E54322E4D41524B4552 PZ56503135 PZ564E3135 PZ53474E44 NZ534C4F542E494E54322E494E NZ534C4F542E494E54322E4F5554 W00_04_EMPTY_SOCKET
.ends MZ4D4F442E534F434B455453
.subckt MZ4D4F442E494E5631 PZ494E PZ4F5554 PZ4A41434B PZ56503135 PZ564E3135 PZ53474E44
RIZ494E56312E524642 PZ4F5554 NZ494E56312E53554D 4.70k
RIZ494E56312E52494E PZ494E NZ494E56312E53554D 4.70k
RIZ494E56312E524F5554 PZ4F5554 PZ4A41434B 100
XIZ4445562E494E5631 PZ53474E44 NZ494E56312E53554D PZ4F5554 PZ56503135 PZ564E3135 PZ53474E44 MZ4445562E494E5631
.ends MZ4D4F442E494E5631
.subckt MZ4D4F442E494E5432 PZ494E PZ4F5554 PZ4A41434B PZ56503135 PZ564E3135 PZ53474E44
CIZ494E54322E434642 PZ4F5554 NZ494E54322E53554D 1u
RIZ494E54322E52494E PZ494E NZ494E54322E53554D 10k
RIZ494E54322E524F5554 PZ4F5554 PZ4A41434B 100
XIZ4445562E494E5432 PZ53474E44 NZ494E54322E53554D PZ4F5554 PZ56503135 PZ564E3135 PZ53474E44 MZ4445562E494E5432
.ends MZ4D4F442E494E5432
.subckt MZ4D4F442E494E5431 PZ494E PZ4F5554 PZ4A41434B PZ56503135 PZ564E3135 PZ53474E44
CIZ494E54312E434642 PZ4F5554 NZ494E54312E53554D 1u
RIZ494E54312E52494E PZ494E NZ494E54312E53554D 10k
RIZ494E54312E524F5554 PZ4F5554 PZ4A41434B 100
XIZ4445562E494E5431 PZ53474E44 NZ494E54312E53554D PZ4F5554 PZ56503135 PZ564E3135 PZ53474E44 MZ4445562E494E5431
.ends MZ4D4F442E494E5431
.subckt MZ494E462E5057525F454E545259 PZ56503135 PZ564E3135 PZ53474E44 PZ50474E44
CIZ494E462E43424E PZ53474E44 PZ564E3135 10u
CIZ494E462E434250 PZ56503135 PZ53474E44 10u
VIZ494E462E474E445F544945 PZ50474E44 PZ53474E44 0
VIZ494E462E564E3135 PZ50474E44 PZ564E3135 15
VIZ494E462E56503135 PZ56503135 PZ50474E44 15
.ends MZ494E462E5057525F454E545259
.subckt MZ4445562E53554D31 PZ494E50 PZ494E4D PZ4F5554 PZ56503135 PZ564E3135 PZ53474E44
XIZ4445562E555F53554D31 PZ494E50 PZ494E4D PZ4F5554 PZ56503135 PZ564E3135 NZ53554D312E434F4D5041 NZ53554D312E434F4D5042 W00_04_IDEAL_OPAMP
CIZ53554D312E43433330 NZ53554D312E434F4D5041 NZ53554D312E434F4D5042 30p
CIZ53554D312E434E PZ494E50 PZ564E3135 0.1u
CIZ53554D312E4350 PZ56503135 PZ494E50 0.1u
.ends MZ4445562E53554D31
.subckt MZ4445562E494E5631 PZ494E50 PZ494E4D PZ4F5554 PZ56503135 PZ564E3135 PZ53474E44
XIZ4445562E555F494E5631 PZ494E50 PZ494E4D PZ4F5554 PZ56503135 PZ564E3135 NZ494E56312E434F4D5041 NZ494E56312E434F4D5042 W00_04_IDEAL_OPAMP
CIZ494E56312E43433330 NZ494E56312E434F4D5041 NZ494E56312E434F4D5042 30p
CIZ494E56312E434E PZ494E50 PZ564E3135 0.1u
CIZ494E56312E4350 PZ56503135 PZ494E50 0.1u
.ends MZ4445562E494E5631
.subckt MZ4445562E494E5433 PZ494E50 PZ494E4D PZ4F5554 PZ503135 PZ4E3135 PZ53474E44
XIZ4445562E555F494E54335F4F5343 PZ494E50 PZ494E4D PZ4F5554 PZ503135 PZ4E3135 NZ4F5343312E494E545F434F4D5041 NZ4F5343312E494E545F434F4D5042 W00_04_IDEAL_OPAMP
CIZ4445562E555F494E54335F4F53432E4343 NZ4F5343312E494E545F434F4D5041 NZ4F5343312E494E545F434F4D5042 30p
CIZ4445562E555F494E54335F4F53432E434E PZ494E50 PZ4E3135 0.1u
CIZ4445562E555F494E54335F4F53432E4350 PZ503135 PZ494E50 0.1u
.ends MZ4445562E494E5433
.subckt MZ4445562E494E5432 PZ494E50 PZ494E4D PZ4F5554 PZ56503135 PZ564E3135 PZ53474E44
XIZ4445562E555F494E5432 PZ494E50 PZ494E4D PZ4F5554 PZ56503135 PZ564E3135 NZ494E54322E434F4D5041 NZ494E54322E434F4D5042 W00_04_IDEAL_OPAMP
CIZ494E54322E43433330 NZ494E54322E434F4D5041 NZ494E54322E434F4D5042 30p
CIZ494E54322E434E PZ494E50 PZ564E3135 0.1u
CIZ494E54322E4350 PZ56503135 PZ494E50 0.1u
.ends MZ4445562E494E5432
.subckt MZ4445562E494E5431 PZ494E50 PZ494E4D PZ4F5554 PZ56503135 PZ564E3135 PZ53474E44
XIZ4445562E555F494E54315F53544F434B PZ494E50 PZ494E4D PZ4F5554 PZ56503135 PZ564E3135 NZ494E54312E434F4D5041 NZ494E54312E434F4D5042 W00_04_IDEAL_OPAMP
CIZ494E54312E4343323230 NZ494E54312E434F4D5041 NZ494E54312E434F4D5042 220p
CIZ494E54312E434E PZ494E50 PZ564E3135 0.1u
CIZ494E54312E4350 PZ56503135 PZ494E50 0.1u
.ends MZ4445562E494E5431
.subckt MZ52454731 PZ56554E524547 PZ564F5554 PZ503135 PZ4E3135 PZ53474E44
CIZ524547312E435F4C4F4144 NZ524547312E434C4F41445F4E PZ53474E44 CL_CASE
CIZ524547312E435F524546 NZ524547312E56524546 PZ53474E44 10u
DIZ524547312E445F4449534348 PZ564F5554 PZ56554E524547 W0506_RECT
DIZ524547312E445F524546 PZ53474E44 NZ524547312E56524546 W0506_Z10
QIZ524547312E515F50415353 PZ56554E524547 NZ524547312E5142415345 NZ524547312E51454D4954 W0506_NPN_BASE
RIZ524547312E525F42415345 NZ524547312E4552525F4F5554 NZ524547312E5142415345 1k
RIZ524547312E525F424C454544 PZ564F5554 PZ53474E44 10k
RIZ524547312E525F454D4954 NZ524547312E51454D4954 PZ564F5554 100
RIZ524547312E525F455352 PZ564F5554 NZ524547312E434C4F41445F4E 0.30
RIZ524547312E525F4C4F4144 PZ564F5554 PZ53474E44 RL_CASE
RIZ524547312E525F524546 PZ503135 NZ524547312E56524546 330
VIZ524547312E565F554E524547 PZ56554E524547 PZ53474E44 18
XIZ4445562E524547312E455252 NZ524547312E56524546 NZ524547312E53454E5345 NZ524547312E4552525F4F5554 PZ503135 PZ4E3135 PZ53474E44 MZ4445562E524547312E455252
.ends MZ52454731
.subckt MZ4F534331 PZ535155415245 PZ545249414E474C45 PZ5643 PZ503135 PZ4E3135 PZ53474E44
CIZ4F5343312E435F494E54 PZ545249414E474C45 NZ4F5343312E494E545F53554D 1u IC=10m
DIZ4F5343312E445F5A4E NZ4F5343312E5A4D4944 PZ53474E44 W0506_Z5V1
DIZ4F5343312E445F5A50 NZ4F5343312E5A4D4944 PZ535155415245 W0506_Z5V1
RIZ4F5343312E525F485953 PZ535155415245 NZ4F5343312E5343484D4954545F53554D 100k
RIZ4F5343312E525F494E54 PZ535155415245 NZ4F5343312E494E545F53554D 1Meg
RIZ4F5343312E525F4C494D4954 NZ4F5343312E5241575F535155415245 PZ535155415245 1k
RIZ4F5343312E525F53434F50455F5351 PZ535155415245 PZ53474E44 10Meg
RIZ4F5343312E525F53434F50455F545249 PZ545249414E474C45 PZ53474E44 10Meg
RIZ4F5343312E525F545249 PZ545249414E474C45 NZ4F5343312E5343484D4954545F53554D 100k
RIZ4F5343312E525F5643 PZ5643 PZ53474E44 10k
XIZ4445562E494E5433 PZ53474E44 NZ4F5343312E494E545F53554D PZ545249414E474C45 PZ503135 PZ4E3135 PZ53474E44 MZ4445562E494E5433
XIZ4445562E4F5343312E5343484D495454 NZ4F5343312E5343484D4954545F53554D PZ53474E44 NZ4F5343312E5241575F535155415245 PZ503135 PZ4E3135 PZ53474E44 MZ4445562E4F5343312E5343484D495454
.ends MZ4F534331
.subckt MZ43484153534953 PZ56503135 PZ564E3135 PZ53474E44 PZ50474E44
XIZ494E462E5057525F454E545259 PZ56503135 PZ564E3135 PZ53474E44 PZ50474E44 MZ494E462E5057525F454E545259
XIZ4D4F442E494E5431 NZ494E54312E494E NZ494E54312E4F5554 NZ494E54312E4A41434B PZ56503135 PZ564E3135 PZ53474E44 MZ4D4F442E494E5431
XIZ4D4F442E494E5432 NZ494E54322E494E NZ494E54322E4F5554 NZ494E54322E4A41434B PZ56503135 PZ564E3135 PZ53474E44 MZ4D4F442E494E5432
XIZ4D4F442E494E5631 NZ494E56312E494E NZ494E56312E4F5554 NZ494E56312E4A41434B PZ56503135 PZ564E3135 PZ53474E44 MZ4D4F442E494E5631
XIZ4D4F442E534F434B455453 PZ56503135 PZ564E3135 PZ53474E44 MZ4D4F442E534F434B455453
XIZ4D4F442E53554D31 NZ53554D312E494E41 NZ53554D312E494E42 NZ53554D312E494E43 NZ53554D312E4F5554 NZ53554D312E4A41434B PZ56503135 PZ564E3135 PZ53474E44 MZ4D4F442E53554D31
XIZ4F534331 NZ4F5343312E535155415245 NZ4F5343312E545249414E474C45 NZ4F5343312E5643 PZ56503135 PZ564E3135 PZ53474E44 MZ4F534331
XIZ52454731 NZ524547312E56554E524547 NZ524547312E564F5554 PZ56503135 PZ564E3135 PZ53474E44 MZ52454731
.ends MZ43484153534953
XIZ43484153534953 NZ503135 NZ4E3135 0 NZ50474E44 MZ43484153534953
.end

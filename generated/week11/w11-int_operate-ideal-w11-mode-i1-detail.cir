.title CAPSTONE.W00_W11 semantic connectivity
.subckt W00_04_IDEAL_OPAMP INP INM OUT VP VN COMPA COMPB
.ends W00_04_IDEAL_OPAMP
.subckt MZ5731312E4D4F44452E4931 PZ5349474E414C5F494E PZ49435F494E PZ53554D PZ4F5554 PZ4E4F4E494E56 PZ4D4F44455F4F50 PZ4D4F44455F525354 PZ56503135 PZ564E3135 PZ41474E44
CIZ5731312E49312E434E PZ41474E44 PZ564E3135 0.1u
CIZ5731312E49312E4350 PZ56503135 PZ41474E44 0.1u
CIZ5731312E49312E435F434F4D50 NZ5731312E49312E434F4D505F41 NZ5731312E49312E434F4D505F42 30p
DIZ5731312E49312E445F4249415331 NZ5731312E49312E4452565F42494153 NZ5731312E49312E424941535F4D4944 W09_D_BASE
DIZ5731312E49312E445F4249415332 NZ5731312E49312E424941535F4D4944 PZ41474E44 W09_D_BASE
DIZ5731312E49312E445F434C414D505F4E PZ41474E44 NZ5731312E49312E52455345545F53454E5345 W09_D_BASE
DIZ5731312E49312E445F434C414D505F50 NZ5731312E49312E52455345545F53454E5345 PZ41474E44 W09_D_BASE
DIZ5731312E49312E445F494E505554 PZ41474E44 NZ5731312E49312E4F505F505245 W09_D_BASE
DIZ5731312E49312E445F4C4F4749435F4F50 NZ5731312E49312E4F505F454D4954 PZ4D4F44455F4F50 W09_D_BASE
DIZ5731312E49312E445F4C4F4749435F525354 NZ5731312E49312E5253545F454D4954 PZ4D4F44455F525354 W09_D_BASE
DIZ5731312E49312E445F4F505F47415445 NZ5731312E49312E4F505F445256 NZ5731312E49312E4F505F47415445 W09_D_BASE
DIZ5731312E49312E445F4F505F474E44 NZ5731312E49312E4F505F445256 PZ41474E44 W09_D_BASE
DIZ5731312E49312E445F5253545F47415445 NZ5731312E49312E5253545F445256 NZ5731312E49312E5253545F47415445 W09_D_BASE
DIZ5731312E49312E445F5253545F474E44 NZ5731312E49312E5253545F445256 PZ41474E44 W09_D_BASE
RIZ5731312E49312E4E4F4E494E565F47524F554E44 PZ4E4F4E494E56 PZ41474E44 0
QIZ5731312E49312E515F4F505F445256 NZ5731312E49312E4F505F445256 NZ5731312E49312E4452565F42494153 NZ5731312E49312E4F505F454D4954 W09_PNP_BASE
QIZ5731312E49312E515F5253545F445256 NZ5731312E49312E5253545F445256 NZ5731312E49312E4452565F42494153 NZ5731312E49312E5253545F454D4954 W09_PNP_BASE
RIZ5731312E49312E52325F424F54544F4D NZ5731312E49312E52455345545F53454E5345 PZ49435F494E 10k
RIZ5731312E49312E52325F544F50 PZ4F5554 NZ5731312E49312E52455345545F53454E5345 10k
RIZ5731312E49312E525F42494153 PZ56503135 NZ5731312E49312E4452565F42494153 100k
RIZ5731312E49312E525F4C4F4749435F4F505F5044 PZ4D4F44455F4F50 PZ41474E44 100k
RIZ5731312E49312E525F4C4F4749435F5253545F5044 PZ4D4F44455F525354 PZ41474E44 100k
RIZ5731312E49312E525F4F50 PZ5349474E414C5F494E NZ5731312E49312E4F505F505245 9.975k
RIZ5731312E49312E525F4F505F454D4954 PZ56503135 NZ5731312E49312E4F505F454D4954 10k
RIZ5731312E49312E525F4F505F47415445 PZ564E3135 NZ5731312E49312E4F505F47415445 15k
RIZ5731312E49312E525F5253545F454D4954 PZ56503135 NZ5731312E49312E5253545F454D4954 10k
RIZ5731312E49312E525F5253545F47415445 PZ564E3135 NZ5731312E49312E5253545F47415445 15k
SIZ5731312E49312E535F4F50 NZ5731312E49312E4F505F505245 PZ53554D NZ5731312E49312E4F505F47415445 PZ41474E44 W11_SW_IDEAL
SIZ5731312E49312E535F525354 NZ5731312E49312E52455345545F4452495645 PZ53554D NZ5731312E49312E5253545F47415445 PZ41474E44 W11_SW_IDEAL
XIZ5731312E49312E555F5245534554 NZ5731312E49312E52455345545F53454E5345 NZ5731312E49312E52455345545F4452495645 NZ5731312E49312E52455345545F4452495645 PZ56503135 PZ564E3135 NZ5731312E49312E434F4D505F41 NZ5731312E49312E434F4D505F42 W00_04_IDEAL_OPAMP
VIZ5731312E49312E565F4F50 PZ4D4F44455F4F50 PZ41474E44 5
VIZ5731312E49312E565F5349474E414C PZ5349474E414C5F494E PZ41474E44 PULSE(-1 1 1m 10u 10u 25m 50m)
.ends MZ5731312E4D4F44452E4931
XIZ5731312E4D4F44452E4931 NZ494E54312E494E NZ5731312E49312E49435F494E NZ414D50312E494E565F494E NZ414D50312E4F5554 NZ414D50312E4E4F4E494E565F494E NZ5731312E49312E4D4F44455F4F50 NZ5731312E49312E4D4F44455F525354 NZ503135 NZ4E3135 0 MZ5731312E4D4F44452E4931
.end

.title ROBERGE.ONEBOX.W00_04 semantic connectivity
.subckt W00_04_IDEAL_OPAMP INP INM OUT VP VN COMPA COMPB
.ends W00_04_IDEAL_OPAMP
.subckt MZ4445562E53554D31 PZ494E50 PZ494E4D PZ4F5554 PZ56503135 PZ564E3135 PZ53474E44
XIZ4445562E555F53554D31 PZ494E50 PZ494E4D PZ4F5554 PZ56503135 PZ564E3135 NZ53554D312E434F4D5041 NZ53554D312E434F4D5042 W00_04_IDEAL_OPAMP
CIZ53554D312E43433330 NZ53554D312E434F4D5041 NZ53554D312E434F4D5042 30p
CIZ53554D312E434E PZ494E50 PZ564E3135 0.1u
CIZ53554D312E4350 PZ56503135 PZ494E50 0.1u
.ends MZ4445562E53554D31
XIZ4445562E53554D31 0 NZ53554D312E53554D NZ53554D312E4F5554 NZ503135 NZ4E3135 0 MZ4445562E53554D31
.end

.title ROBERGE.ONEBOX.W00_04 semantic connectivity
.subckt W00_04_EMPTY_SOCKET VP VN GND IN OUT
.ends W00_04_EMPTY_SOCKET
.subckt W00_04_IDEAL_OPAMP INP INM OUT VP VN COMPA COMPB
.ends W00_04_IDEAL_OPAMP
.subckt MZ4D4F442E53554D31 PZ494E41 PZ494E42 PZ494E43 PZ4F5554 PZ4A41434B PZ56503135 PZ564E3135 PZ53474E44
RIZ53554D312E524642 PZ4F5554 NZ53554D312E53554D 10k
RIZ53554D312E52494E5F41 OZ53554D312E52494E5F410050 NZ53554D312E53554D 10k
RIZ53554D312E52494E5F42 OZ53554D312E52494E5F420050 NZ53554D312E53554D 10k
RIZ53554D312E52494E5F43 OZ53554D312E52494E5F430050 NZ53554D312E53554D 10k
RIZ53554D312E524F5554 PZ4F5554 PZ4A41434B 100
XIZ4445562E53554D31 PZ53474E44 NZ53554D312E53554D PZ4F5554 PZ56503135 PZ564E3135 PZ53474E44 MZ4445562E53554D31
.ends MZ4D4F442E53554D31
.subckt MZ4D4F442E534F434B455453 PZ56503135 PZ564E3135 PZ53474E44
XIZ534C4F542E494E54322E4D41524B4552 PZ56503135 PZ564E3135 PZ53474E44 NZ534C4F542E494E54322E494E NZ534C4F542E494E54322E4F5554 W00_04_EMPTY_SOCKET
XIZ534C4F542E494E54332E4D41524B4552 PZ56503135 PZ564E3135 PZ53474E44 NZ534C4F542E494E54332E494E NZ534C4F542E494E54332E4F5554 W00_04_EMPTY_SOCKET
.ends MZ4D4F442E534F434B455453
.subckt MZ4D4F442E494E5631 PZ494E PZ4F5554 PZ4A41434B PZ56503135 PZ564E3135 PZ53474E44
RIZ494E56312E524642 PZ4F5554 NZ494E56312E53554D 4.70k
RIZ494E56312E52494E NZ4649582E494E56 NZ494E56312E53554D 4.70k
RIZ494E56312E524F5554 PZ4F5554 PZ4A41434B 100
XIZ4445562E494E5631 PZ53474E44 NZ494E56312E53554D PZ4F5554 PZ56503135 PZ564E3135 PZ53474E44 MZ4445562E494E5631
.ends MZ4D4F442E494E5631
.subckt MZ4D4F442E494E5431 PZ494E PZ4F5554 PZ4A41434B PZ56503135 PZ564E3135 PZ53474E44
CIZ494E54312E434642 PZ4F5554 NZ494E54312E53554D 1u
RIZ494E54312E52494E OZ494E54312E52494E0050 NZ494E54312E53554D 10k
RIZ494E54312E524F5554 PZ4F5554 PZ4A41434B 100
XIZ4445562E494E5431 PZ53474E44 NZ494E54312E53554D PZ4F5554 PZ56503135 PZ564E3135 PZ53474E44 MZ4445562E494E5431
.ends MZ4D4F442E494E5431
.subckt MZ4D4541532E46495854555245 PZ53474E44
RIZ4649582E524C4F4144 NZ494E56312E4A41434B PZ53474E44 10Meg
VIZ4649582E565F494E56 NZ4649582E494E56 PZ53474E44 DC 1
.ends MZ4D4541532E46495854555245
.subckt MZ494E462E5057525F454E545259 PZ56503135 PZ564E3135 PZ53474E44 PZ50474E44
CIZ494E462E43424E PZ53474E44 PZ564E3135 10u
CIZ494E462E434250 PZ56503135 PZ53474E44 10u
VIZ494E462E474E445F544945 PZ50474E44 PZ53474E44 0
VIZ494E462E564E3135 PZ50474E44 PZ564E3135 15
VIZ494E462E56503135 PZ56503135 PZ50474E44 15
.ends MZ494E462E5057525F454E545259
.subckt MZ4445562E53554D31 PZ494E50 PZ494E4D PZ4F5554 PZ56503135 PZ564E3135 PZ53474E44
XIZ4445562E555F53554D31 PZ494E50 PZ494E4D PZ4F5554 PZ56503135 PZ564E3135 NZ53554D312E434F4D5041 NZ53554D312E434F4D5042 W00_04_IDEAL_OPAMP
CIZ53554D312E43433330 NZ53554D312E434F4D5041 NZ53554D312E434F4D5042 30p
CIZ53554D312E434E PZ494E50 PZ564E3135 0.1u
CIZ53554D312E4350 PZ56503135 PZ494E50 0.1u
.ends MZ4445562E53554D31
.subckt MZ4445562E494E5631 PZ494E50 PZ494E4D PZ4F5554 PZ56503135 PZ564E3135 PZ53474E44
XIZ4445562E555F494E5631 PZ494E50 PZ494E4D PZ4F5554 PZ56503135 PZ564E3135 NZ494E56312E434F4D5041 NZ494E56312E434F4D5042 W00_04_IDEAL_OPAMP
CIZ494E56312E43433330 NZ494E56312E434F4D5041 NZ494E56312E434F4D5042 30p
CIZ494E56312E434E PZ494E50 PZ564E3135 0.1u
CIZ494E56312E4350 PZ56503135 PZ494E50 0.1u
.ends MZ4445562E494E5631
.subckt MZ4445562E494E5431 PZ494E50 PZ494E4D PZ4F5554 PZ56503135 PZ564E3135 PZ53474E44
XIZ4445562E555F494E54315F53544F434B PZ494E50 PZ494E4D PZ4F5554 PZ56503135 PZ564E3135 NZ494E54312E434F4D5041 NZ494E54312E434F4D5042 W00_04_IDEAL_OPAMP
CIZ494E54312E43433330 NZ494E54312E434F4D5041 NZ494E54312E434F4D5042 30p
CIZ494E54312E434E PZ494E50 PZ564E3135 0.1u
CIZ494E54312E4350 PZ56503135 PZ494E50 0.1u
.ends MZ4445562E494E5431
.subckt MZ43484153534953 PZ56503135 PZ564E3135 PZ53474E44 PZ50474E44
XIZ494E462E5057525F454E545259 PZ56503135 PZ564E3135 PZ53474E44 PZ50474E44 MZ494E462E5057525F454E545259
XIZ4D4541532E46495854555245 PZ53474E44 MZ4D4541532E46495854555245
XIZ4D4F442E494E5431 NZ494E54312E494E NZ494E54312E4F5554 NZ494E54312E4A41434B PZ56503135 PZ564E3135 PZ53474E44 MZ4D4F442E494E5431
XIZ4D4F442E494E5631 NZ494E56312E494E NZ494E56312E4F5554 NZ494E56312E4A41434B PZ56503135 PZ564E3135 PZ53474E44 MZ4D4F442E494E5631
XIZ4D4F442E534F434B455453 PZ56503135 PZ564E3135 PZ53474E44 MZ4D4F442E534F434B455453
XIZ4D4F442E53554D31 NZ53554D312E494E41 NZ53554D312E494E42 NZ53554D312E494E43 NZ53554D312E4F5554 NZ53554D312E4A41434B PZ56503135 PZ564E3135 PZ53474E44 MZ4D4F442E53554D31
.ends MZ43484153534953
XIZ43484153534953 NZ503135 NZ4E3135 0 NZ50474E44 MZ43484153534953
.end

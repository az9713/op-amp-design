.title OP_AMPS_ROBERGE_W12 semantic connectivity
.subckt W00_04_IDEAL_OPAMP INP INM OUT VP VN COMPA COMPB
.ends W00_04_IDEAL_OPAMP
.subckt MZ5731332E5245472E434C4F41445F434F4D50 PZ5052454F5554 PZ4F5554 PZ53454E5345
CIZ5731332E5245472E435F46 PZ5052454F5554 PZ53454E5345 C_F
RIZ5731332E5245472E525F4650415448 PZ4F5554 PZ53454E5345 R_FPATH
.ends MZ5731332E5245472E434C4F41445F434F4D50
.subckt MZ4445562E524547312E455252 PZ494E50 PZ494E4D PZ4F5554 PZ503135 PZ4E3135 PZ53474E44 PZ434F4D5041 PZ434F4D5042
CIZ524547312E4343 PZ434F4D5041 PZ434F4D5042 30p
CIZ524547312E434E PZ53474E44 PZ4E3135 0.1u
CIZ524547312E4350 PZ503135 PZ53474E44 0.1u
XIZ524547312E555F455252 PZ494E50 PZ494E4D PZ4F5554 PZ503135 PZ4E3135 PZ434F4D5041 PZ434F4D5042 W00_04_IDEAL_OPAMP
.ends MZ4445562E524547312E455252
.subckt MZ494E462E5057525F454E545259 PZ56503135 PZ564E3135 PZ53474E44 PZ50474E44
CIZ494E462E43424E PZ53474E44 PZ564E3135 10u
CIZ494E462E434250 PZ56503135 PZ53474E44 10u
VIZ494E462E474E445F544945 PZ50474E44 PZ53474E44 0
VIZ494E462E564E3135 PZ50474E44 PZ564E3135 15
VIZ494E462E56503135 PZ56503135 PZ50474E44 15
.ends MZ494E462E5057525F454E545259
.subckt MZ52454731 PZ56554E524547 PZ564F5554 PZ503135 PZ4E3135 PZ53474E44 PZ51454D4954 PZ53454E5345 PZ434F4D5041 PZ434F4D5042
CIZ524547312E435F4C4F4144 NZ524547312E434C4F41445F4E PZ53474E44 CL_CASE
CIZ524547312E435F524546 NZ524547312E56524546 PZ53474E44 10u
DIZ524547312E445F4449534348 PZ564F5554 PZ56554E524547 W0506_RECT
DIZ524547312E445F524546 PZ53474E44 NZ524547312E56524546 W0506_Z10
IIZ524547312E495F44495354 PZ564F5554 PZ53474E44 PULSE(0 10m 20m 10u 10u 20m 100m)
QIZ524547312E515F50415353 PZ56554E524547 NZ524547312E5142415345 PZ51454D4954 W0506_NPN_BASE
RIZ524547312E525F42415345 NZ524547312E4552525F4F5554 NZ524547312E5142415345 1k
RIZ524547312E525F424C454544 PZ564F5554 PZ53474E44 10k
RIZ524547312E525F454D4954 PZ51454D4954 PZ564F5554 100
RIZ524547312E525F455352 PZ564F5554 NZ524547312E434C4F41445F4E 0.30
RIZ524547312E525F4C4F4144 PZ564F5554 PZ53474E44 RL_CASE
RIZ524547312E525F524546 PZ503135 NZ524547312E56524546 330
RIZ524547312E525F53434F5045 PZ564F5554 PZ53474E44 10Meg
VIZ524547312E565F554E524547 PZ56554E524547 PZ53474E44 18
XIZ4445562E524547312E455252 NZ524547312E56524546 PZ53454E5345 NZ524547312E4552525F4F5554 PZ503135 PZ4E3135 PZ53474E44 PZ434F4D5041 PZ434F4D5042 MZ4445562E524547312E455252
.ends MZ52454731
.subckt MZ43484153534953 PZ56503135 PZ564E3135 PZ53474E44 PZ50474E44
XIZ494E462E5057525F454E545259 PZ56503135 PZ564E3135 PZ53474E44 PZ50474E44 MZ494E462E5057525F454E545259
XIZ52454731 NZ524547312E56554E524547 NZ524547312E564F5554 PZ56503135 PZ564E3135 PZ53474E44 NZ524547312E51454D4954 NZ524547312E53454E5345 NZ524547312E434F4D5041 NZ524547312E434F4D5042 MZ52454731
XIZ5731332E5245472E434C4F41445F434F4D50 NZ524547312E51454D4954 NZ524547312E564F5554 NZ524547312E53454E5345 MZ5731332E5245472E434C4F41445F434F4D50
.ends MZ43484153534953
XIZ43484153534953 NZ503135 NZ4E3135 0 NZ50474E44 MZ43484153534953
.end
